simulator lang=spectre
global 0
; NOTE: replace with your own PDK model file. Original: CSMC 0.18um, sm1816m50v13_usage.scs, section=tt_lib
include "/path/to/your/pdk/model.scs" section=tt_lib

subckt SMC VINN VINP VOUT IBIAS VDD VSS
NM4 (VOUT IBIAS VSS VSS) mn18 w=2e-07 l=5e-07 //// Load transistor, 2nd stage
NM0 (net27 VINN net26 VSS) mn18 w=2e-07 l=5e-07 //// Input transistor, 1st stage ``NM1``
NM3 (IBIAS IBIAS VSS VSS) mn18 w=1e-06 l=1e-06 //// Bias transistor, ``not``
NM2 (net26 IBIAS VSS VSS) mn18 w=2e-07 l=5e-07 //// Current transistor, 1st stage
NM1 (net28 VINP net26 VSS) mn18 w=2e-07 l=5e-07 //// Input transistor, 1st stage ``NM0``
PM2 (VOUT net28 VDD VDD) mp18 w=2e-07 l=5e-07 //// Input transistor, 2nd stage
PM1 (net27 net27 VDD VDD) mp18 w=2e-07 l=5e-07 //// Load transistor, 1st stage ``PM0``
PM0 (net28 net27 VDD VDD) mp18 w=2e-07 l=5e-07 //// Load transistor, 1st stage ``PM1``
C0 (net28 VOUT) capacitor c=1p //// Miller cap
ends SMC

            V0 (VSS 0) vsource dc=0 type=dc
            V1 (VDD 0) vsource dc=1.8 type=dc
            C0 (VOUT VSS) capacitor c=1e-11
            I0 (VDD IBIAS) isource dc=3e-06 type=dc
            I1 (VOUT VINP VOUT IBIAS VDD VSS) SMC
            V2 (VINP 0) vsource type=pulse val0=1.2 val1=0.6 period=1e-05 rise=1p fall=1p
