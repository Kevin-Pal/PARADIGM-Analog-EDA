subckt NGCC VINN VINP VOUT IBIAS VDD VSS
NM9 (net041 net035 VSS VSS) mn18 w=1u l=180n ////the **Load** transistor of the 2nd stage
NM7 (IBIASP IBIAS VSS VSS) mn18 w=1u l=180n ////bias transistor. should not be changed
NM6 (IBIAS IBIAS VSS VSS) mn18 w=1u l=180n  ////bias transistor. should not be changed
NM5 (net020 IBIAS VSS VSS) mn18 w=1u l=180n ////
NM4 (VOUT net041 VSS VSS) mn18 w=1u l=180n ////**Input** transistor of the Load stage
NM0 (net27 VINN net26 VSS) mn18 w=1u l=180n ////**Input** transistor of 1st(gm1) stage ``NM1``
NM8 (net035 net035 VSS VSS) mn18 w=1u l=180n ////the **Load** transistor of the 2nd stage
NM2 (net26 IBIAS VSS VSS) mn18 w=1u l=180n ////current tail transistor of the 1st stage
NM1 (net28 VINP net26 VSS) mn18 w=1u l=180n ////**Input** transistor of 1st(gm1) stage ``NM0``
PM9 (VOUT net28 VDD VDD) mp18 w=1u l=180n ////the **Input** transistor of gmf2
PM8 (net035 net28 VDD VDD) mp18 w=1u l=180n ////**Input** transistor of the 2nd stage
PM7 (net041 IBIASP VDD VDD) mp18 w=1u l=180n ////**Load** transistor of the 2nd stage
PM6 (IBIASP IBIASP VDD VDD) mp18 w=1u l=180n ////bias transistor. should not be changed
PM5 (VOUT net020 VDD VDD) mp18 w=1u l=180n ////the Input transistor of the gmf1
PM4 (net020 net020 VDD VDD) mp18 w=1u l=180n ////
PM3 (net020 net27 VDD VDD) mp18 w=1u l=180n ////
PM2 (VOUT IBIASP VDD VDD) mp18 w=1u l=180n ////**Load** transistor of the Load stage
PM1 (net27 net27 VDD VDD) mp18 w=1u l=180n ////Load transistor of the 1st stage ``PM0``
PM0 (net28 net27 VDD VDD) mp18 w=1u l=180n ////**Load** transistor in the 1st stage ``PM1``
C1 (net041 VOUT) capacitor c=1p ////miller cap between the 2nd stage and the output
C0 (net28 VOUT) capacitor c=1p ////miller cap between the 1st stage and the output
ends NGCC
