simulator lang=spectre
global 0
; NOTE: replace with your own PDK model file. Original: CSMC 0.18um, sm1816m50v13_usage.scs, section=tt_lib
include "/path/to/your/pdk/model.scs" section=tt_lib

subckt NGCC VINN VINP VOUT IBIAS VDD VSS
NM9 (net041 net035 VSS VSS) mn18 w=2e-07 l=5e-07 ////the **Load** transistor of the 2nd stage
NM7 (IBIASP IBIAS VSS VSS) mn18 w=2e-07 l=5e-07 ////bias transistor. should not be changed
NM6 (IBIAS IBIAS VSS VSS) mn18 w=2e-07 l=5e-07  ////bias transistor. should not be changed
NM5 (net020 IBIAS VSS VSS) mn18 w=2e-07 l=5e-07 ////
NM4 (VOUT net041 VSS VSS) mn18 w=2e-07 l=5e-07 ////**Input** transistor of the Load stage
NM0 (net27 VINN net26 VSS) mn18 w=2e-07 l=5e-07 ////**Input** transistor of 1st(gm1) stage ``NM1``
NM8 (net035 net035 VSS VSS) mn18 w=2e-07 l=5e-07 ////the **Load** transistor of the 2nd stage
NM2 (net26 IBIAS VSS VSS) mn18 w=2e-07 l=5e-07 ////current tail transistor of the 1st stage
NM1 (net28 VINP net26 VSS) mn18 w=2e-07 l=5e-07 ////**Input** transistor of 1st(gm1) stage ``NM0``
PM9 (VOUT net28 VDD VDD) mp18 w=2e-07 l=5e-07 ////the **Input** transistor of gmf2
PM8 (net035 net28 VDD VDD) mp18 w=2e-07 l=5e-07 ////**Input** transistor of the 2nd stage
PM7 (net041 IBIASP VDD VDD) mp18 w=2e-07 l=5e-07 ////**Load** transistor of the 2nd stage
PM6 (IBIASP IBIASP VDD VDD) mp18 w=2e-07 l=5e-07 ////bias transistor. should not be changed
PM5 (VOUT net020 VDD VDD) mp18 w=2e-07 l=5e-07 ////the Input transistor of the gmf1
PM4 (net020 net020 VDD VDD) mp18 w=2e-07 l=5e-07 ////
PM3 (net020 net27 VDD VDD) mp18 w=2e-07 l=5e-07 ////
PM2 (VOUT IBIASP VDD VDD) mp18 w=2e-07 l=5e-07 ////**Load** transistor of the Load stage
PM1 (net27 net27 VDD VDD) mp18 w=2e-07 l=5e-07 ////Load transistor of the 1st stage ``PM0``
PM0 (net28 net27 VDD VDD) mp18 w=2e-07 l=5e-07 ////**Load** transistor in the 1st stage ``PM1``
C1 (net041 VOUT) capacitor c=1p ////miller cap between the 2nd stage and the output
C0 (net28 VOUT) capacitor c=1p ////miller cap between the 1st stage and the output
ends NGCC

            V0 (VSS 0) vsource dc=0 type=dc
            V1 (VDD 0) vsource dc=1.8 type=dc
            C0 (VOUT VSS) capacitor c=5e-11
            I0 (VDD IBIAS) isource dc=3e-07 type=dc
            I1 (VOUT VINP VOUT IBIAS VDD VSS) NGCC
            V2 (VINP 0) vsource type=pulse val0=1.2 val1=0.6 period=0.0001 rise=1p fall=1p
