simulator lang=spectre
global 0
; NOTE: replace with your own PDK model file. Original: CSMC 0.18um, sm1816m50v13_usage.scs, section=tt_lib
include "/path/to/your/pdk/model.scs" section=tt_lib

subckt NMCNR VINN VINP VOUT IBIAS VDD VSS
NM7 (IBIASP IBIAS VSS VSS) mn18 w=2e-07 l=5e-07 //// Bias transistor
NM6 (net021 net028 VSS VSS) mn18 w=2e-07 l=5e-07 //// **Load** transistor, 2nd stage
NM5 (VOUT net021 VSS VSS) mn18 w=2e-07 l=5e-07 //// **Input** transistor, load(3rd) stage
NM4 (net028 net028 VSS VSS) mn18 w=2e-07 l=5e-07 //// **Load** transistor, 2nd stage
NM0 (net27 VINN net26 VSS) mn18 w=2e-07 l=5e-07 //// **Input** transistor, 1st stage ``NM1``
NM3 (IBIAS IBIAS VSS VSS) mn18 w=2e-07 l=5e-07 //// Bias transistor
NM2 (net26 IBIAS VSS VSS) mn18 w=2e-07 l=5e-07 //// Current tail transistor, 1st stage
NM1 (net28 VINP net26 VSS) mn18 w=2e-07 l=5e-07 //// **Input** transistor, 1st stage ``NM0``
PM5 (IBIASP IBIASP VDD VDD) mp18 w=2e-07 l=5e-07 //// Bias transistor
PM4 (net021 IBIASP VDD VDD) mp18 w=2e-07 l=5e-07 //// **Load** transistor, 2nd stage
PM3 (VOUT IBIASP VDD VDD) mp18 w=2e-07 l=5e-07 //// **Load** transistor, load(3rd) stage
PM2 (net028 net28 VDD VDD) mp18 w=2e-07 l=5e-07 //// **Input** transistor, 2nd stage
PM1 (net27 net27 VDD VDD) mp18 w=2e-07 l=5e-07 //// **Load** transistor, 1st stage ``PM0``
PM0 (net28 net27 VDD VDD) mp18 w=2e-07 l=5e-07 //// **Load** transistor, 1st stage ``PM1``
C1 (net021 net027) capacitor c=1p //// Miller cap 1
C0 (net28 net027) capacitor c=1p //// Miller cap 2
R0 (net027 VOUT) resistor r=1K//// Nulling resistor
ends NMCNR

            V0 (VSS 0) vsource dc=0 type=dc
            V1 (VDD 0) vsource dc=1.8 type=dc
            C0 (VOUT VSS) capacitor c=5e-11
            I0 (VDD IBIAS) isource dc=3e-07 type=dc
            I1 (VOUT VINP VOUT IBIAS VDD VSS) NMCNR
            V2 (VINP 0) vsource type=pulse val0=1.2 val1=0.6 period=2e-05 rise=1p fall=1p
